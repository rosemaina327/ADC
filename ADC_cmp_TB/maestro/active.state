ADE simulation setup
Test TERASCALE_srv1:ADC_cmp_TB:1: TERASCALE_srv1/ADC_cmp_TB/schematic, simulator spectre
  Models: /adl/design_kits/AMS/c18-h18-hitkit411//spectre/h18/mcparams.scs, /adl/design_kits/AMS/c18-h18-hitkit411//spectre/h18/design.scs[noitm], /adl/design_kits/AMS/c18-h18-hitkit411//spectre/h18/res.scs[restm], /adl/design_kits/AMS/c18-h18-hitkit411//spectre/h18/cap.scs[captm], /adl/design_kits/AMS/c18-h18-hitkit411//spectre/h18/bip.scs[biptm], /adl/design_kits/AMS/c18-h18-hitkit411//spectre/h18/esddi.scs[esdditm], /adl/design_kits/AMS/c18-h18-hitkit411//spectre/h18/cmos53.scs[cmostm]
  Variables: Ibias = 20u; inwidn = 0.7u; lenin = 200n; vsignal = 2.35m; widn = 700n; widp = 700n; tau = 5n; vin = 1.1
  Temperature: 27
  Simulator options: reltol=100e-6 homotopy=all limit=delta
  Analysis dc: (saves the operating point)
  Analysis tran: stop=0.1u errpreset=moderate
  Signals: /vin, /vdac, /outc, /out1c, /cmp
Run mode: Single Run, Sweeps and Corners
