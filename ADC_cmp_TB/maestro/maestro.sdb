ADE simulation setup
Run mode: Single Run, Sweeps and Corners
Tests:
  TERASCALE_srv1_sol:ADC_cmp_TB:1: TERASCALE_srv1_sol/ADC_cmp_TB/schematic, simulator spectre
    Variables: Ibias = 10u; inwidn = 0.7u; lenin = 200n; vsignal = 2.35m; widn = 700n; widp = 700n; tau = 5n; vin = 1.1
