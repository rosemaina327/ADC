ADE simulation setup
Test TERASCALE_srv1_ADC_cmp_lay_1: TERASCALE_srv1/ADC_cmp_lay/schematic, simulator spectre
  Temperature: 27
