ADE simulation setup
Test TERASCALE_srv1_sol:AMP2_TB:1: TERASCALE_srv1_sol/AMP2_TB/schematic, simulator spectre
  Models: /adl/design_kits/AMS/c18-h18-hitkit411//spectre/h18/soac/mcparams.scs, /adl/design_kits/AMS/c18-h18-hitkit411//spectre/h18/soac/design.scs[noitm], /adl/design_kits/AMS/c18-h18-hitkit411//spectre/h18/soac/res.scs[restm], /adl/design_kits/AMS/c18-h18-hitkit411//spectre/h18/soac/cap.scs[captm], /adl/design_kits/AMS/c18-h18-hitkit411//spectre/h18/soac/bip.scs[biptm], /adl/design_kits/AMS/c18-h18-hitkit411//spectre/h18/soac/esddi.scs[esdditm], /adl/design_kits/AMS/c18-h18-hitkit411//spectre/h18/cmos53.scs[cmostm]
  Variables: ifb = 50p; rfb = 1G; s1 = 1; sall = 10; isig = 250n; cdet = 100f; widn = 700n; widp = 700n
  Temperature: 27
  Simulator options: reltol=100e-6 homotopy=all limit=delta
  Analysis dc: (saves the operating point)
  Analysis noise: start=1 stop=100G p=/outcsa n=/gnd! iprobe=/Idet
  Analysis tran: stop=20u errpreset=conservative
  Signals: /outcsa, /in
Run mode: Single Run, Sweeps and Corners
