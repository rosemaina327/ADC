ADE simulation setup
Run mode: Single Run, Sweeps and Corners
Tests:
  TERASCALE_srv1_sol:AMP2_TB:1: TERASCALE_srv1_sol/AMP2_TB/schematic, simulator spectre
    Variables: ifb = 50p; rfb = 1G; s1 = 1; sall = 10; isig = 250n; cdet = 100f; widn = 700n; widp = 700n
