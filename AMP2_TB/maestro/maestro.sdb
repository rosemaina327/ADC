ADE simulation setup
Run mode: Monte Carlo Sampling
Tests:
  TERASCALE_srv1:AMP2_TB:1: TERASCALE_srv1/AMP2_TB/schematic, simulator spectre
    Variables: ifb = 50p; rfb = 1G; s1 = 1; sall = 10; isig = 250n; cdet = 100f; widn = 700n; widp = 700n
Monte Carlo Sampling options: mcnumpoints=5, yeyistostart=3.0, reliabilitymode=singlestress, mcSigmaTarget=3, sssnumpoints=7000, yeexpectedyield=3, mcmethod=mismatch, wcdinitialpoints=200, yeiterations=10, yeusehistorymc=0, yeuseautomcsamples=1, yecreatecorners=0, haveyeyieldtostart=1, yeusevarreduction=1
