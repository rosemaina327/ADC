ADE simulation setup
Run mode: Single Run, Sweeps and Corners
Tests:
  TERASCALE_srv1_sol:ADC_tb_mm:1: TERASCALE_srv1_sol/ADC_tb_mm/schematic, simulator spectre
    Variables: vstart = 1; VSS = 1.8; rswitch = 100; lenin = 200n; inwidn = 700n; rfb = 1G; isig = 750n; sall = 10; inscale = 1; s1 = 1; cdet = 100f; widn = 700n; widp = 700n; tau = 5n
    Outputs: /analog
