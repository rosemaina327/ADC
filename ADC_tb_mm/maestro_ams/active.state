ADE simulation setup
Test TERASCALE_srv1:ADC_tb_mm:1: TERASCALE_srv1/ADC_tb_mm/config, simulator ams
  Models: /adl/design_kits/AMS/c18-h18-hitkit411//spectre/h18/mcparams.scs, /adl/design_kits/AMS/c18-h18-hitkit411//spectre/h18/design.scs[noitm], /adl/design_kits/AMS/c18-h18-hitkit411//spectre/h18/res.scs[restm], /adl/design_kits/AMS/c18-h18-hitkit411//spectre/h18/cap.scs[captm], /adl/design_kits/AMS/c18-h18-hitkit411//spectre/h18/bip.scs[biptm], /adl/design_kits/AMS/c18-h18-hitkit411//spectre/h18/esddi.scs[esdditm], /adl/design_kits/AMS/c18-h18-hitkit411//spectre/h18/cmos53.scs[cmostm]
  Variables: vstart = 1; VSS = 1.8; rswitch = 100k; lenin = 200n; inwidn = 700n; rfb = 1G; isig = 750n; sall = 10; inscale = 1; s1 = 1; cdet = 100f; widn = 700n; widp = 700n; tau = 5n
  Temperature: 27
  Simulator options: reltol=100e-6 homotopy=all limit=delta
  Analysis tran: stop=5u errpreset=liberal
  Analysis dc: (saves the operating point)
  Signals: /Iadc/vdac, /Iadc/vinsh, /outcsa, /digital_out<7:0>
Run mode: Single Run, Sweeps and Corners
