ADE simulation setup
Test TERASCALE:AMP1_TB:1: TERASCALE/AMP1_TB/schematic, simulator spectre
  Models: /adl/design_kits/AMS/c18-h18-hitkit411//spectre/h18/soac/mcparams.scs, /adl/design_kits/AMS/c18-h18-hitkit411//spectre/h18/soac/design.scs[noitm], /adl/design_kits/AMS/c18-h18-hitkit411//spectre/h18/soac/res.scs[restm], /adl/design_kits/AMS/c18-h18-hitkit411//spectre/h18/soac/cap.scs[captm], /adl/design_kits/AMS/c18-h18-hitkit411//spectre/h18/soac/bip.scs[biptm], /adl/design_kits/AMS/c18-h18-hitkit411//spectre/h18/soac/esddi.scs[esdditm], /home/iperic/soac/cmos53.scs[cmostm]
  Variables: rfb = 1G; s1 = 1; sall = 10; isig = 250n; cdet = 100f; widn = 700n; widp = 700n
  Temperature: 27
  Simulator options: reltol=100e-6 homotopy=all limit=delta
  Analysis dc: (saves the operating point)
  Analysis noise: start=1 stop=100G p=/outcsa n=/gnd! iprobe=/Idet
  Analysis tran: stop=20u errpreset=conservative
  Output (riseTime((VT("/outcsa") - VDC("/outcsa")) 0 nil ymax((VT("/outcsa") - VDC("/outcsa"))) nil 0 95 nil "time") / 3)
  Output ymax((VT("/outcsa") - VDC("/outcsa")))
  Output ((1500 * rmsNoise(1 1000000000)) / ymax((VT("/outcsa") - VDC("/outcsa"))))
  Output rms((VT("/outcsa") - VDC("/outcsa")))
  Signals: /outcsa, /in
