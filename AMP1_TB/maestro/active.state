ADE simulation setup
Test TERASCALE_srv1_AMP1_TB_1: TERASCALE_srv1/AMP1_TB/schematic, simulator spectre
  Models: /adl/design_kits/AMS/c18-h18-hitkit411//spectre/h18/mcparams.scs, /adl/design_kits/AMS/c18-h18-hitkit411/spectre/h18/bip.scs[biptm], /adl/design_kits/AMS/c18-h18-hitkit411/spectre/h18/cap.scs[captm], /adl/design_kits/AMS/c18-h18-hitkit411/spectre/h18/cmos53.scs[cmostm], /adl/design_kits/AMS/c18-h18-hitkit411/spectre/h18/design.scs[noitm], /adl/design_kits/AMS/c18-h18-hitkit411/spectre/h18/esddi.scs[esdditm], /adl/design_kits/AMS/c18-h18-hitkit411/spectre/h18/res.scs[restm]
  Variables: rfb = 1G; s1 = 1; sall = 1; isig = 250n; cdet = 100f; widn = 700n; widp = 700n
  Temperature: 27
  Analysis dc: (saves the operating point)
  Analysis noise: start=1 stop=100G p=/outcsa n=/gnd! oprobe=/outcsa iprobe=/Idet
  Analysis tran: stop=20u errpreset=conservative
  Signals: /outcsa, /in
Run mode: Single Run, Sweeps and Corners
