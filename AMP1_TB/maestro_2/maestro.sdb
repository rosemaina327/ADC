ADE simulation setup
Run mode: Single Run, Sweeps and Corners
Tests:
  TERASCALE_srv1_AMP1_TB_1: TERASCALE_srv1/AMP1_TB/schematic, simulator spectre
    Variables: rfb = 1G; s1 = 1; sall = {Inclusion List}10{Inclusion List}{From/To}Auto:1:5:20{From/To}; isig = 250n; cdet = 100f; widn = 700n; widp = 700n
